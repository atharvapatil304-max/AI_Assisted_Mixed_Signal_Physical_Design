* Week 6 post-layout template
* Replace __EXTRACTED_SPICE__ and pin/cell details with the actual
* extracted netlist generated by Magic.
.include "__EXTRACTED_SPICE__"

VDD VDD 0 3.3
VSS VSS 0 0
VI0 I0 0 PULSE(2 2 0 1n 1n 20n 40n)
VI1 I1 0 PULSE(1 1 0 1n 1n 20n 40n)
VSEL SEL 0 PULSE(0 3.3 5n 100p 100p 10n 20n)

* Replace this instance with the actual extracted top-cell name/pin order.
Xdut I0 I1 SEL OUT VDD VSS amux2_3v_new

.tran 10p 40n
.control
run
plot v(I0) v(I1) v(SEL) v(OUT)
.endc
.end
