*===========================================================
* amux2_dh.spice
* 2:1 Analog Multiplexer (Double Height)
* Sky130 Transistor-Level Implementation
*
* Pins:
*   IN0  - Input 0
*   IN1  - Input 1
*   SEL  - Select
*   OUT  - Output
*   VPWR - 1.8V Supply
*   VGND - Ground
*===========================================================

.subckt amux2_dh IN0 IN1 SEL OUT VPWR VGND

*-----------------------------------------------------------
* Select Inverter
*-----------------------------------------------------------

M1 SELB SEL VGND VGND sky130_fd_pr__nfet_01v8 L=0.5u W=0.65u
M2 SELB SEL VPWR VPWR sky130_fd_pr__pfet_01v8 L=0.5u W=1.3u

*-----------------------------------------------------------
* Transmission Gate for IN0
* ON when SEL = 0
*-----------------------------------------------------------

M3 OUT SELB IN0 VGND sky130_fd_pr__nfet_01v8 L=0.5u W=1.5u
M4 OUT SEL  IN0 VPWR sky130_fd_pr__pfet_01v8 L=0.5u W=3.0u

*-----------------------------------------------------------
* Transmission Gate for IN1
* ON when SEL = 1
*-----------------------------------------------------------

M5 OUT SEL  IN1 VGND sky130_fd_pr__nfet_01v8 L=0.5u W=1.5u
M6 OUT SELB IN1 VPWR sky130_fd_pr__pfet_01v8 L=0.5u W=3.0u

.ends amux2_dh
