* ==========================================================================
* amux2_dh_tb.spice
* Transistor-level 2:1 analog MUX, double-height target cell "amux2_dh"
* Built from two CMOS transmission gates + a select inverter.
* Uses REAL SkyWater sky130_fd_pr__nfet_01v8 / pfet_01v8 tt-corner models
* (cloned from github.com/google/skywater-pdk-libs-sky130_fd_pr)
* ==========================================================================

* Statistical/mismatch "slope" multipliers - normally supplied by the
* top-level sky130.lib.spice corner-selection wrapper (not redistributed
* standalone); set to 0 here to select the pure typical-typical corner
* with no process-variation skew, which is the correct tt-corner behavior.
.param sky130_fd_pr__nfet_01v8__toxe_slope=0 sky130_fd_pr__nfet_01v8__vth0_slope=0
.param sky130_fd_pr__nfet_01v8__vth0_slope1=0 sky130_fd_pr__nfet_01v8__voff_slope=0
.param sky130_fd_pr__pfet_01v8__toxe_slope=0 sky130_fd_pr__pfet_01v8__toxe_slope1=0
.param sky130_fd_pr__pfet_01v8__vth0_slope=0 sky130_fd_pr__pfet_01v8__vth0_slope1=0
.param sky130_fd_pr__pfet_01v8__voff_slope=0 sky130_fd_pr__pfet_01v8__voff_slope1=0
.param sky130_fd_pr__pfet_01v8__nfactor_slope=0 sky130_fd_pr__pfet_01v8__nfactor_slope1=0
* Layout-dependent-effect (stress/LOD) parameters - normally supplied by a
* separate SkyWater LOD parameter file; zeroed here (= no LOD derating,
* the standard assumption for a hand netlist not yet placed in a layout).
.param sky130_fd_pr__pfet_01v8__wlod_diff=0 sky130_fd_pr__pfet_01v8__kvth0_diff=0
.param sky130_fd_pr__pfet_01v8__lkvth0_diff=0 sky130_fd_pr__pfet_01v8__wkvth0_diff=0
.param sky130_fd_pr__pfet_01v8__ku0_diff=0 sky130_fd_pr__pfet_01v8__lku0_diff=0
.param sky130_fd_pr__pfet_01v8__wku0_diff=0 sky130_fd_pr__pfet_01v8__kvsat_diff=0
.param sky130_fd_pr__nfet_01v8__wlod_diff=0 sky130_fd_pr__nfet_01v8__kvth0_diff=0
.param sky130_fd_pr__nfet_01v8__lkvth0_diff=0 sky130_fd_pr__nfet_01v8__wkvth0_diff=0
.param sky130_fd_pr__nfet_01v8__ku0_diff=0 sky130_fd_pr__nfet_01v8__lku0_diff=0
.param sky130_fd_pr__nfet_01v8__wku0_diff=0 sky130_fd_pr__nfet_01v8__kvsat_diff=0

.include "models/sky130_fd_pr__nfet_01v8__tt.corner.spice"
.include "models/sky130_fd_pr__pfet_01v8__tt.corner.spice"

.param VDD=1.8

* --- Transmission gate 0: passes IN0 when SEL=0 (SELB=1 turns on PMOS, SEL=0 turns off... )
* Convention: NMOS gate=SEL, PMOS gate=SELB -> TG0 ON when SEL=0
XN0 OUT SEL  IN0 0   sky130_fd_pr__nfet_01v8 l=0.5u w=1.5u
XP0 OUT SELB IN0 VPWR sky130_fd_pr__pfet_01v8 l=0.5u w=3.0u

* --- Transmission gate 1: passes IN1 when SEL=1
XN1 OUT SELB IN1 0    sky130_fd_pr__nfet_01v8 l=0.5u w=1.5u
XP1 OUT SEL  IN1 VPWR sky130_fd_pr__pfet_01v8 l=0.5u w=3.0u

* --- Select inverter: SEL -> SELB
XNINV SELB SEL 0    0    sky130_fd_pr__nfet_01v8 l=0.5u w=0.65u
XPINV SELB SEL VPWR VPWR sky130_fd_pr__pfet_01v8 l=0.5u w=1.3u

* --- Supplies and stimulus
VDDSRC VPWR 0 DC {VDD}
VIN0   IN0  0 DC 0.6
VIN1   IN1  0 DC 1.2
* Load capacitance representing next-stage input (rough estimate pre-layout)
CLOAD  OUT 0 5f

* SEL toggles 0 -> 1 at 20n, then 1 -> 0 at 60n, each edge 200ps, held 40n
VSEL SEL 0 PULSE(0 {VDD} 20n 200p 200p 40n 80n)

.tran 10p 100n

.control
run
* propagation delay SEL(50%) -> OUT(50%) for the 0->1 transition around t=20n
* SEL rises 0->1 at t=20n: TG behavior here switches OUT from IN1(1.2V) to IN0(0.6V), a falling OUT edge
meas tran tpd_sel_rise_out_fall TRIG v(sel) VAL=0.9 RISE=1 TARG v(out) VAL=0.9 FALL=1
* SEL falls 1->0 at t=60n: OUT switches from IN0(0.6V) back to IN1(1.2V), a rising OUT edge
meas tran tpd_sel_fall_out_rise TRIG v(sel) VAL=0.9 FALL=1 TARG v(out) VAL=0.9 RISE=1
meas tran tr_out TRIG v(out) VAL=0.66 RISE=1 TARG v(out) VAL=1.14 RISE=1
meas tran tf_out TRIG v(out) VAL=1.14 FALL=1 TARG v(out) VAL=0.66 FALL=1
wrdata amux2_dh_tb_results.txt v(sel) v(selb) v(in0) v(in1) v(out)
.endc
.end
