*=========================================================
* 2:1 Analog Multiplexer
* SKY130A Technology
*=========================================================

.include "sky130.lib.spice"

.param VDD = 1.8

************************************************
* Power Supplies
************************************************

VDD VPWR 0 DC {VDD}
VSS VGND 0 DC 0

************************************************
* Analog Inputs
************************************************

VA A 0 DC 0.5
VB B 0 DC 1.5

************************************************
* Select Signal
************************************************

VSEL SEL 0 PULSE(0 1.8 5n 100p 100p 10n 20n)

************************************************
* Inverter for SEL_B
************************************************

M1 SEL_B SEL VPWR VPWR sky130_fd_pr__pfet_01v8 W=1.0 L=0.15
M2 SEL_B SEL VGND VGND sky130_fd_pr__nfet_01v8 W=0.42 L=0.15

************************************************
* Transmission Gate A
************************************************

M3 X A SEL_B VPWR sky130_fd_pr__pfet_01v8 W=1.0 L=0.15
M4 X A SEL VGND VGND sky130_fd_pr__nfet_01v8 W=0.42 L=0.15

************************************************
* Transmission Gate B
************************************************

M5 X B SEL VPWR sky130_fd_pr__pfet_01v8 W=1.0 L=0.15
M6 X B SEL_B VGND VGND sky130_fd_pr__nfet_01v8 W=0.42 L=0.15

.end
